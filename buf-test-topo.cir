*TEST BUFORA BEZPOSREDNI
.inc tsmc180_t77a_spice.lib

.include ./bufor.spice

VSQR sqr VSS PULSE(0 {vdd} {tsqr/2} 1p 1p {tsqr/2} {tsqr})
VSS VSS 0 0
VDD VDD 0 {vdd}

RS X sqr 50
CL Y VSS 25p

.param vdd=1.8 fsqr=100e6 tsqr={1/fsqr}
;.temp 125
;.step param fsqr 30e6 100e6 10e6 ; test czestotliwosci
;.step temp -30 125 30 ; test temperaturowy
;.step param vdd 1.62 1.98 0.06 ; test napiecia zasilania

.tran 0 {5*tsqr} 0 {tsqr/100}

.end
